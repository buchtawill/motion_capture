// isp_regs.rdl
// KV260 / OV9281 ISP statistics & control register map.
//
// The module measures:
//   - Frame rate              (via free-running cycle counter + frame counter
//                              with matched snapshot registers)
//   - Average pixel brightness (via PIXEL_SUM from the last measured frame)
//   - 256-bin pixel histogram  (indirect access through HIST_ADDR / HIST_DATA)
//
// Pixel path is 8-bit. Histogram has 256 bins of up to 20-bit count.
//
// Register summary (each register occupies 4 bytes of address space):
//   0x00  CTRL           R/W   Control (W-pulses + HIST_ADDR_AUTOINC)
//   0x04  STATUS         RO    HW-driven status
//   0x08  HRES           R/W   Horizontal resolution (16b)
//   0x0C  VRES           R/W   Vertical resolution   (16b)
//   0x10  CYCLE_CNT_LO   RO    Free-running cycle counter, low 32b
//   0x14  CYCLE_CNT_HI   RO    Free-running cycle counter, high 32b
//   0x18  CYCLE_SNAP_LO  RO    Cycle counter snapshot, low 32b
//   0x1C  CYCLE_SNAP_HI  RO    Cycle counter snapshot, high 32b
//   0x20  FRAME_CNT      RO    Frame counter (increments on TUSER & TVALID & TREADY)
//   0x24  FRAME_SNAP     RO    Frame counter snapshot
//   0x28  PIXEL_SUM      RO    Sum of pixel values from last measured frame
//   0x2C  HIST_ADDR      R/W   Histogram bin index  (8b,  bits 31:8 reserved)
//   0x30  HIST_DATA      RO    Histogram bin count  (20b, bits 31:20 reserved)
//
// A SW reset (CTRL.RESET = 1) clears all counters, snapshots, and re-issues a
// histogram RAM scrub; it does NOT reset HRES / VRES.

addrmap isp_regs {
    desc = "KV260 ISP AXI4-Lite register map: frame-rate, pixel-brightness,
            and 256-bin pixel histogram statistics. 8-bit pixels.";

    // =========================================================
    // 0x00: Control
    //  - Bits 0, 1, 2, 4, 5 are write-only single-pulse (auto-clear)
    //  - Bit 3 (HIST_ADDR_AUTOINC) is sticky R/W
    // =========================================================
    reg ctrl_reg {
        desc = "ISP control register.";

        field { hw = r; sw = w; singlepulse; } RESET[1]             = 0;
        // Bit 0: SW reset. Clears all counters and snapshots and kicks off
        //        a histogram RAM scrub. Does NOT reset HRES or VRES.

        field { hw = r; sw = w; singlepulse; } HISTOGRAM_START[1]   = 0;
        // Bit 1: Begin histogram + pixel-sum measurement.
        //        Ignored if STATUS.READY = 0 or if HRES / VRES are zero.
        //        The module re-issues a RAM scrub, waits for scrub done,
        //        waits for the next TUSER & TVALID & TREADY, then enables
        //        hist_en_i and counts HRES*VRES pixels before deasserting
        //        hist_en_i and setting STATUS.HIST_DATA_VALID.

        field { hw = r; sw = w; singlepulse; } SNAPSHOT[1]          = 0;
        // Bit 2: Latch the cycle and frame counters into their snapshot
        //        registers (coherent read of 64-bit cycle + frame count).

        field { hw = r; sw = rw; }             HIST_ADDR_AUTOINC[1] = 1;
        // Bit 3: When 1, HIST_ADDR auto-increments (wrapping at 0xFF)
        //        after each HIST_DATA read. Defaults to 1.

        field { hw = r; sw = w; singlepulse; } FRAME_CNT_RESET[1]   = 0;
        // Bit 4: Reset the frame counter and FRAME_SNAP.

        field { hw = r; sw = w; singlepulse; } CYCLE_CNT_RESET[1]   = 0;
        // Bit 5: Reset the cycle counter (LO+HI) and its snapshot.

        field { hw = r; sw = w; singlepulse; } IRQ_CLEAR[1]         = 0;
        // Bit 6: Clear the FRAME_DONE_IRQ latch (write 1 to deassert the
        //        interrupt output).
    };

    // =========================================================
    // 0x04: Status (RO, HW-driven)
    // =========================================================
    reg status_reg {
        desc = "ISP status register (RO).";

        default hw = w;
        default sw = r;

        field {} READY[1]           = 0;
        // Bit 0: 1 when the module is idle and ready to accept
        //        HISTOGRAM_START. 0 during the initial post-reset scrub
        //        or while a measurement is in progress.

        field {} HIST_DATA_VALID[1] = 0;
        // Bit 1: Histogram and PIXEL_SUM contain valid data for the last
        //        measurement. Cleared on reset, SW reset, and when a new
        //        measurement starts.

        field {} HIST_FIFO_ERR[1]   = 0;
        // Bit 2: Sticky. Set by isp_histogram when the ingress FIFO
        //        overflows and pixel beats are dropped. Cleared only by
        //        RTL reset or CTRL.RESET.

        field {} FRAME_DONE_IRQ[1] = 0;
        // Bit 3: Latched high when a histogram measurement completes
        //        (DATA_VALID rising edge). Drives frame_done_irq_o.
        //        Cleared by CTRL.IRQ_CLEAR or CTRL.RESET.
    };

    // =========================================================
    // 0x08: Horizontal Resolution (R/W, 16b, preserved across SW reset)
    // =========================================================
    reg hres_reg {
        desc = "Horizontal resolution in pixels (e.g. 1280). Must be non-zero
                before asserting CTRL.HISTOGRAM_START. Preserved across SW reset.";
        field { hw = r; sw = rw; } HRES[16] = 16'd1280;
    };

    // =========================================================
    // 0x0C: Vertical Resolution (R/W, 16b, preserved across SW reset)
    // =========================================================
    reg vres_reg {
        desc = "Vertical resolution in lines (e.g. 800). Must be non-zero
                before asserting CTRL.HISTOGRAM_START. Preserved across SW reset.";
        field { hw = r; sw = rw; } VRES[16] = 16'd800;
    };

    // =========================================================
    // 0x10 / 0x14: Free-running cycle counter (64b)
    // =========================================================
    reg cycle_cnt_lo_reg {
        desc = "Lower 32 bits of free-running cycle counter.
                Write CTRL.SNAPSHOT before reading for a coherent 64b value.";
        field { hw = w; sw = r; } CYCLE_CNT_LO[32] = 0;
    };
    reg cycle_cnt_hi_reg {
        desc = "Upper 32 bits of free-running cycle counter.";
        field { hw = w; sw = r; } CYCLE_CNT_HI[32] = 0;
    };

    // =========================================================
    // 0x18 / 0x1C: Cycle counter snapshot (64b)
    // =========================================================
    reg cycle_snap_lo_reg {
        desc = "Lower 32 bits of cycle counter snapshot. Latched on CTRL.SNAPSHOT.";
        field { hw = w; sw = r; } CYCLE_SNAP_LO[32] = 0;
    };
    reg cycle_snap_hi_reg {
        desc = "Upper 32 bits of cycle counter snapshot. Latched on CTRL.SNAPSHOT.";
        field { hw = w; sw = r; } CYCLE_SNAP_HI[32] = 0;
    };

    // =========================================================
    // 0x20: Frame Counter (RO)
    // =========================================================
    reg frame_cnt_reg {
        desc = "Frame counter. Increments once per TUSER & TVALID & TREADY
                (i.e. the first accepted beat of each frame from the MIPI CSI
                RX subsystem). Reset by CTRL.RESET and CTRL.FRAME_CNT_RESET.";
        field { hw = w; sw = r; } FRAME_CNT[32] = 0;
    };

    // =========================================================
    // 0x24: Frame Counter Snapshot (RO)
    // =========================================================
    reg frame_snap_reg {
        desc = "Frame counter snapshot. Latched on CTRL.SNAPSHOT; coherent with
                the cycle counter snapshot.";
        field { hw = w; sw = r; } FRAME_SNAP[32] = 0;
    };

    // =========================================================
    // 0x28: Pixel-value sum from the last measured frame (32b RO)
    // =========================================================
    reg pixel_sum_reg {
        desc = "Sum of all pixel values from the last measured frame.
                Valid when STATUS.HIST_DATA_VALID = 1. Count enable tracks
                the same hist_en_i that drives the histogram.
                32 bits is sufficient for an 8-bit 1280x800 image
                (max sum = 255 * 1_024_000 ~= 2.6e8).
                This value matches sum(bin_count[i] * i) for i in 0..255.";
        field { hw = w; sw = r; } PIXEL_SUM[32] = 0;
    };

    // =========================================================
    // 0x2C: Histogram bin address (R/W, 8b, HW-writable for auto-increment)
    // =========================================================
    reg hist_addr_reg {
        desc = "Histogram bin index. Selects which bin is presented on HIST_DATA.
                Auto-increments (wrapping at 0xFF) on each HIST_DATA read when
                CTRL.HIST_ADDR_AUTOINC = 1. Bits [31:8] are reserved / read 0.";
        field { hw = rw; sw = rw; we; } HIST_ADDR[8] = 0;
    };

    // =========================================================
    // 0x30: Histogram bin data (RO, 20b)
    // =========================================================
    reg hist_data_reg {
        desc = "Histogram bin count at the address selected by HIST_ADDR.
                Reading this register auto-increments HIST_ADDR when
                CTRL.HIST_ADDR_AUTOINC = 1. Bits [31:20] are reserved / read 0.";
        field { hw = w; sw = r; } HIST_DATA[20] = 0;
    };

    // =========================================================
    // Address Map
    // =========================================================
    ctrl_reg          CTRL          @ 0x000;
    status_reg        STATUS        @ 0x004;
    hres_reg          HRES          @ 0x008;
    vres_reg          VRES          @ 0x00C;
    cycle_cnt_lo_reg  CYCLE_CNT_LO  @ 0x010;
    cycle_cnt_hi_reg  CYCLE_CNT_HI  @ 0x014;
    cycle_snap_lo_reg CYCLE_SNAP_LO @ 0x018;
    cycle_snap_hi_reg CYCLE_SNAP_HI @ 0x01C;
    frame_cnt_reg     FRAME_CNT     @ 0x020;
    frame_snap_reg    FRAME_SNAP    @ 0x024;
    pixel_sum_reg     PIXEL_SUM     @ 0x028;
    hist_addr_reg     HIST_ADDR     @ 0x02C;
    hist_data_reg     HIST_DATA     @ 0x030;
};
