// isp_regs.rdl
// OV9281 ISP Statistics and Control Registers
//
// 0x00: Control (WO)
//  - Bit 0 - Reset:               Writing 1 = SW reset (auto-clears)
//  - Bit 1 - Start:               Writing 1 starts measurement (auto-clears)
//  - Bit 2 - Snapshot:            Writing 1 snapshots cycle/frame counters (auto-clears)
//  - Bit 3 - HIST_ADDR_AUTOINC:   Auto-increment HIST_ADDR on HIST_DATA access. Default 1.
// 0x04: Status (RO)
//  - Bit 0: Busy. 1 when measurement in progress.
//  - Bit 1: Data ready. New data available. Clears when START is written.
// 0x08: Horizontal resolution (R/W)
// 0x0C: Vertical resolution (R/W)
// 0x10: Cycle counter low (RO)
// 0x14: Cycle counter high (RO)
// 0x18: Cycle counter snapshot low (RO)
// 0x1C: Cycle counter snapshot high (RO)
// 0x20: Frame counter (RO)
// 0x24: Frame counter snapshot (RO)
// 0x28: Average pixel value from last frame (RO)
// 0x2C: Histogram bin address (R/W)
// 0x30: Histogram bin data (R/W) — indirect access to BRAM via HIST_ADDR


addrmap isp_regs {
    desc = "OV9281 ISP AXI4-Lite Register Map";

    // =========================================================
    // 0x00: Control Register (mixed: bits 0-2 auto-clear, bit 3 sticky)
    // =========================================================
    reg ctrl_reg {
        desc = "ISP Control Register.";

        // Bits 0-2: write-only, auto-clear (singlepulse)
        field {
            hw = r; sw = w;
            singlepulse;
        } RESET[1] = 0;
        // Bit 0: Software reset. Clears all counters and state machines.

        field {
            hw = r; sw = w;
            singlepulse;
        } START[1] = 0;
        // Bit 1: Start measurement. Waits for next TUSER strobe.
        // Also clears DATA_READY.

        field {
            hw = r; sw = w;
            singlepulse;
        } SNAPSHOT[1] = 0;
        // Bit 2: Snapshot. Latches cycle and frame counters into snapshot registers.

        // Bit 3: sticky R/W control — not a pulse
        field {
            hw = r; sw = rw;
        } HIST_ADDR_AUTOINC[1] = 1;
        // Bit 3: When 1, HIST_ADDR auto-increments after each HIST_DATA access.
        // Implemented in RTL (isp_math_top), not in the register block itself.
        // Defaults to 1.
    };

    // =========================================================
    // 0x04: Status Register (RO)
    // =========================================================
    reg status_reg {
        desc = "ISP Status Register. Read-only, driven by hardware.";

        default hw = rw;
        default sw = r;

        field {} BUSY[1] = 0;
        // Bit 0: Set when measurement is in progress.

        field {} DATA_READY[1] = 0;
        // Bit 1: Set when a frame measurement has completed.
        // Cleared when SW writes CTRL.START.
    };

    // =========================================================
    // 0x08: Horizontal Resolution (R/W)
    // =========================================================
    reg hres_reg {
        desc = "Horizontal resolution in pixels (e.g. 1280 for OV9281).
                Must be set before writing CTRL.START.";

        default hw = r;
        default sw = rw;

        field {} HRES[16] = 16'd1280;
    };

    // =========================================================
    // 0x0C: Vertical Resolution (R/W)
    // =========================================================
    reg vres_reg {
        desc = "Vertical resolution in lines (e.g. 800 for OV9281).
                Must be set before writing CTRL.START.";

        default hw = r;
        default sw = rw;

        field {} VRES[16] = 16'd800;
    };

    // =========================================================
    // 0x10: Cycle Counter Low (RO)
    // =========================================================
    reg cycle_cnt_lo_reg {
        desc = "Lower 32 bits of free-running cycle counter.
                Write CTRL.SNAPSHOT before reading for a coherent 64-bit value.";

        default hw = rw;
        default sw = r;

        field {} CYCLE_CNT_LO[32] = 0;
    };

    // =========================================================
    // 0x14: Cycle Counter High (RO)
    // =========================================================
    reg cycle_cnt_hi_reg {
        desc = "Upper 32 bits of free-running cycle counter.";

        default hw = rw;
        default sw = r;

        field {} CYCLE_CNT_HI[32] = 0;
    };

    // =========================================================
    // 0x18: Cycle Counter Snapshot Low (RO)
    // =========================================================
    reg cycle_snap_lo_reg {
        desc = "Lower 32 bits of cycle counter snapshot.
                Updated when SW writes CTRL.SNAPSHOT.";

        default hw = rw;
        default sw = r;

        field {} CYCLE_SNAP_LO[32] = 0;
    };

    // =========================================================
    // 0x1C: Cycle Counter Snapshot High (RO)
    // =========================================================
    reg cycle_snap_hi_reg {
        desc = "Upper 32 bits of cycle counter snapshot.";

        default hw = rw;
        default sw = r;

        field {} CYCLE_SNAP_HI[32] = 0;
    };

    // =========================================================
    // 0x20: Frame Counter (RO)
    // =========================================================
    reg frame_cnt_reg {
        desc = "Monotonic frame counter. Increments on each completed frame.
                Reset by CTRL.RESET. Read CTRL.SNAPSHOT first for coherent read.";

        default hw = rw;
        default sw = r;

        field {} FRAME_CNT[32] = 0;
    };

    // =========================================================
    // 0x24: Frame Counter Snapshot (RO)
    // =========================================================
    reg frame_snap_reg {
        desc = "Snapshot of frame counter at the time CTRL.SNAPSHOT was written.
                Coherent with CYCLE_SNAP_LO/HI.";

        default hw = rw;
        default sw = r;

        field {} FRAME_SNAP[32] = 0;
    };

    // =========================================================
    // 0x28: Average Pixel Value (RO)
    // =========================================================
    reg avg_pixel_reg {
        desc = "Mean pixel brightness from the last completed frame.
                Computed as sum(pixels) / (HRES * VRES). Range 0-255.
                Updated when DATA_READY is set.";

        default hw = rw;
        default sw = r;

        field {} AVG_PIXEL[8] = 0;
    };

    // =========================================================
    // 0x2C: Histogram Bin Address (R/W)
    // =========================================================
    reg hist_addr_reg {
        desc = "Index (0-255) of the histogram bin to read or write via HIST_DATA.
                If CTRL.HIST_ADDR_AUTOINC=1, hardware increments this register
                after each HIST_DATA access. Wraps at 255.";

        default hw = rw;
        default sw = rw;

        field {} HIST_ADDR[8] = 0;
        // Bits 7:0 — bin index. Bits 31:8 reserved.
    };

    // =========================================================
    // 0x30: Histogram Bin Data (R/W)
    // =========================================================
    reg hist_data_reg {
        desc = "Data register for indirect BRAM histogram access.
                Read: returns pixel count for bin at HIST_ADDR (BRAM output).
                Write: stores value into BRAM at HIST_ADDR.
                Hardware drives this register with BRAM read data each cycle.
                Auto-increment of HIST_ADDR (if enabled) is handled in RTL.";

        default hw = rw;
        default sw = rw;

        field {} HIST_DATA[32] = 0;
    };

    // =========================================================
    // Address Map
    // =========================================================
    ctrl_reg          CTRL          @ 0x000;
    status_reg        STATUS        @ 0x004;
    hres_reg          HRES          @ 0x008;
    vres_reg          VRES          @ 0x00C;
    cycle_cnt_lo_reg  CYCLE_CNT_LO  @ 0x010;
    cycle_cnt_hi_reg  CYCLE_CNT_HI  @ 0x014;
    cycle_snap_lo_reg CYCLE_SNAP_LO @ 0x018;
    cycle_snap_hi_reg CYCLE_SNAP_HI @ 0x01C;
    frame_cnt_reg     FRAME_CNT     @ 0x020;
    frame_snap_reg    FRAME_SNAP    @ 0x024;
    avg_pixel_reg     AVG_PIXEL     @ 0x028;
    hist_addr_reg     HIST_ADDR     @ 0x02C;
    hist_data_reg     HIST_DATA     @ 0x030;
};
